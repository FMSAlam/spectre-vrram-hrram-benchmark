// ====================================================================
// INCA 2T1R Direct-Convolution Cell Subcircuit - Ta2O5 Variant
// Architecture: Kim et al. (HPCA 2023) | Material: Ta2O5
// ====================================================================
simulator lang=spectre

ahdl_include "../../veriloga/memristor_ta2o5.va"

subckt inca_2t1r_cell_ta2o5 (input_pillar row_sel col_sel plane_out gnd)
    parameters x0=0.3

    // 1. Ta2O5 Memristor element between Input Pillar and internal node 'n1'
    Xmem (input_pillar n1) memristor_ta2o5 x0=x0

    // 2. Transistor 1: Row-wise gating switch (TR1)
    M1 (n1 row_sel n2 gnd) NMOS_VTG w=240n l=45n

    // 3. Transistor 2: Column-wise gating switch (TR2)
    M2 (n2 col_sel plane_out gnd) NMOS_VTG w=240n l=45n
ends inca_2t1r_cell_ta2o5
